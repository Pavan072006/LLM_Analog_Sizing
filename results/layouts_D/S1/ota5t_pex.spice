* NGSPICE file created from ota5t.ext - technology: gf180mcuD

.subckt ota5t B VSS IBIAS VN VP VDD OUT
X0 a_n9706_n894# VP a_n9246_1446# B nfet_03v3 ad=2.1616p pd=8.28u as=2.1616p ps=8.28u w=7.72u l=1.7u
X1 a_n9706_n894# VN OUT B nfet_03v3 ad=2.1616p pd=8.28u as=2.1616p ps=8.28u w=7.72u l=1.7u
X2 a_n9706_n894# VP a_n9246_1446# B nfet_03v3 ad=2.1616p pd=8.28u as=2.1616p ps=8.28u w=7.72u l=1.7u
X3 B B B B nfet_03v3 ad=0.9164p pd=4.32u as=39.4864p ps=0.15008m w=1.58u l=1.75u
X4 a_n9706_n894# VP a_n9246_1446# B nfet_03v3 ad=2.1616p pd=8.28u as=2.1616p ps=8.28u w=7.72u l=1.7u
X5 a_n9246_1446# VP a_n9706_n894# B nfet_03v3 ad=2.1616p pd=8.28u as=2.1616p ps=8.28u w=7.72u l=1.7u
X6 a_n9706_n894# VP a_n9246_1446# B nfet_03v3 ad=2.1616p pd=8.28u as=2.1616p ps=8.28u w=7.72u l=1.7u
X7 a_n9246_1446# VP a_n9706_n894# B nfet_03v3 ad=2.1616p pd=8.28u as=4.632p ps=16.64u w=7.72u l=1.7u
X8 OUT VN a_n9706_n894# B nfet_03v3 ad=2.1616p pd=8.28u as=2.1616p ps=8.28u w=7.72u l=1.7u
X9 B B B B nfet_03v3 ad=4.4776p pd=16.6u as=0 ps=0 w=7.72u l=1.7u
X10 OUT VN a_n9706_n894# B nfet_03v3 ad=2.1616p pd=8.28u as=2.1616p ps=8.28u w=7.72u l=1.7u
X11 OUT VN a_n9706_n894# B nfet_03v3 ad=2.1616p pd=8.28u as=2.1616p ps=8.28u w=7.72u l=1.7u
X12 a_n9246_1446# VP a_n9706_n894# B nfet_03v3 ad=4.632p pd=16.64u as=2.1616p ps=8.28u w=7.72u l=1.7u
X13 a_n9246_1446# VP a_n9706_n894# B nfet_03v3 ad=2.1616p pd=8.28u as=2.1616p ps=8.28u w=7.72u l=1.7u
X14 OUT VN a_n9706_n894# B nfet_03v3 ad=2.1616p pd=8.28u as=4.632p ps=16.64u w=7.72u l=1.7u
X15 a_n9706_n894# VN OUT B nfet_03v3 ad=2.1616p pd=8.28u as=2.1616p ps=8.28u w=7.72u l=1.7u
X16 B B B B nfet_03v3 ad=0.9164p pd=4.32u as=0 ps=0 w=1.58u l=1.75u
X17 a_n9706_n894# VN OUT B nfet_03v3 ad=2.1616p pd=8.28u as=2.1616p ps=8.28u w=7.72u l=1.7u
X18 OUT VN a_n9706_n894# B nfet_03v3 ad=2.1616p pd=8.28u as=2.1616p ps=8.28u w=7.72u l=1.7u
X19 a_n9706_n894# VN OUT B nfet_03v3 ad=2.1616p pd=8.28u as=2.1616p ps=8.28u w=7.72u l=1.7u
X20 a_n9706_n894# VP a_n9246_1446# B nfet_03v3 ad=2.1616p pd=8.28u as=2.1616p ps=8.28u w=7.72u l=1.7u
X21 a_n9706_n894# IBIAS VSS B nfet_03v3 ad=0.948p pd=4.36u as=0.948p ps=4.36u w=1.58u l=1.75u
X22 a_n9246_1446# VP a_n9706_n894# B nfet_03v3 ad=2.1616p pd=8.28u as=2.1616p ps=8.28u w=7.72u l=1.7u
X23 OUT VN a_n9706_n894# B nfet_03v3 ad=2.1616p pd=8.28u as=2.1616p ps=8.28u w=7.72u l=1.7u
X24 a_n9246_1446# VP a_n9706_n894# B nfet_03v3 ad=2.1616p pd=8.28u as=2.1616p ps=8.28u w=7.72u l=1.7u
X25 a_n9706_n894# VP a_n9246_1446# B nfet_03v3 ad=2.1616p pd=8.28u as=2.1616p ps=8.28u w=7.72u l=1.7u
X26 a_n9706_n894# VN OUT B nfet_03v3 ad=2.1616p pd=8.28u as=2.1616p ps=8.28u w=7.72u l=1.7u
X27 OUT VN a_n9706_n894# B nfet_03v3 ad=2.1616p pd=8.28u as=2.1616p ps=8.28u w=7.72u l=1.7u
X28 a_n9706_n894# VN OUT B nfet_03v3 ad=2.1616p pd=8.28u as=2.1616p ps=8.28u w=7.72u l=1.7u
X29 OUT VN a_n9706_n894# B nfet_03v3 ad=2.1616p pd=8.28u as=2.1616p ps=8.28u w=7.72u l=1.7u
X30 a_n9706_n894# VP a_n9246_1446# B nfet_03v3 ad=2.1616p pd=8.28u as=2.1616p ps=8.28u w=7.72u l=1.7u
X31 IBIAS IBIAS VSS B nfet_03v3 ad=0.948p pd=4.36u as=0.948p ps=4.36u w=1.58u l=1.75u
X32 VDD VDD VDD VDD pfet_03v3 ad=2.5288p pd=9.88u as=15.3472p ps=59.36u w=4.36u l=0.33u
X33 a_n9246_1446# VP a_n9706_n894# B nfet_03v3 ad=2.1616p pd=8.28u as=2.1616p ps=8.28u w=7.72u l=1.7u
X34 a_n9706_n894# VN OUT B nfet_03v3 ad=2.1616p pd=8.28u as=2.1616p ps=8.28u w=7.72u l=1.7u
X35 a_n9706_n894# VP a_n9246_1446# B nfet_03v3 ad=2.1616p pd=8.28u as=2.1616p ps=8.28u w=7.72u l=1.7u
X36 a_n9706_n894# VP a_n9246_1446# B nfet_03v3 ad=2.1616p pd=8.28u as=2.1616p ps=8.28u w=7.72u l=1.7u
X37 a_n9246_1446# VP a_n9706_n894# B nfet_03v3 ad=4.632p pd=16.64u as=2.1616p ps=8.28u w=7.72u l=1.7u
X38 OUT VN a_n9706_n894# B nfet_03v3 ad=2.1616p pd=8.28u as=2.1616p ps=8.28u w=7.72u l=1.7u
X39 a_n9706_n894# VN OUT B nfet_03v3 ad=2.1616p pd=8.28u as=2.1616p ps=8.28u w=7.72u l=1.7u
X40 a_n9246_1446# a_n9246_1446# VDD VDD pfet_03v3 ad=2.616p pd=9.92u as=2.616p ps=9.92u w=4.36u l=0.33u
X41 a_n9246_1446# VP a_n9706_n894# B nfet_03v3 ad=2.1616p pd=8.28u as=2.1616p ps=8.28u w=7.72u l=1.7u
X42 a_n9706_n894# VP a_n9246_1446# B nfet_03v3 ad=2.1616p pd=8.28u as=2.1616p ps=8.28u w=7.72u l=1.7u
X43 OUT VN a_n9706_n894# B nfet_03v3 ad=2.1616p pd=8.28u as=4.632p ps=16.64u w=7.72u l=1.7u
X44 a_n9706_n894# VN OUT B nfet_03v3 ad=2.1616p pd=8.28u as=2.1616p ps=8.28u w=7.72u l=1.7u
X45 a_n9246_1446# VP a_n9706_n894# B nfet_03v3 ad=2.1616p pd=8.28u as=2.1616p ps=8.28u w=7.72u l=1.7u
X46 B B B B nfet_03v3 ad=4.4776p pd=16.6u as=0 ps=0 w=7.72u l=1.7u
X47 B B B B nfet_03v3 ad=4.4776p pd=16.6u as=0 ps=0 w=7.72u l=1.7u
X48 VDD VDD VDD VDD pfet_03v3 ad=2.5288p pd=9.88u as=0 ps=0 w=4.36u l=0.33u
X49 OUT VN a_n9706_n894# B nfet_03v3 ad=2.1616p pd=8.28u as=2.1616p ps=8.28u w=7.72u l=1.7u
X50 OUT VN a_n9706_n894# B nfet_03v3 ad=2.1616p pd=8.28u as=2.1616p ps=8.28u w=7.72u l=1.7u
X51 a_n9246_1446# VP a_n9706_n894# B nfet_03v3 ad=2.1616p pd=8.28u as=4.632p ps=16.64u w=7.72u l=1.7u
X52 a_n9246_1446# VP a_n9706_n894# B nfet_03v3 ad=2.1616p pd=8.28u as=2.1616p ps=8.28u w=7.72u l=1.7u
X53 a_n9706_n894# VP a_n9246_1446# B nfet_03v3 ad=2.1616p pd=8.28u as=2.1616p ps=8.28u w=7.72u l=1.7u
X54 a_n9706_n894# VP a_n9246_1446# B nfet_03v3 ad=2.1616p pd=8.28u as=2.1616p ps=8.28u w=7.72u l=1.7u
X55 a_n9706_n894# VN OUT B nfet_03v3 ad=2.1616p pd=8.28u as=2.1616p ps=8.28u w=7.72u l=1.7u
X56 a_n9706_n894# VP a_n9246_1446# B nfet_03v3 ad=2.1616p pd=8.28u as=2.1616p ps=8.28u w=7.72u l=1.7u
X57 a_n9246_1446# VP a_n9706_n894# B nfet_03v3 ad=2.1616p pd=8.28u as=2.1616p ps=8.28u w=7.72u l=1.7u
X58 a_n9706_n894# VP a_n9246_1446# B nfet_03v3 ad=2.1616p pd=8.28u as=2.1616p ps=8.28u w=7.72u l=1.7u
X59 a_n9706_n894# VP a_n9246_1446# B nfet_03v3 ad=2.1616p pd=8.28u as=2.1616p ps=8.28u w=7.72u l=1.7u
X60 a_n9246_1446# VP a_n9706_n894# B nfet_03v3 ad=2.1616p pd=8.28u as=2.1616p ps=8.28u w=7.72u l=1.7u
X61 OUT VN a_n9706_n894# B nfet_03v3 ad=2.1616p pd=8.28u as=2.1616p ps=8.28u w=7.72u l=1.7u
X62 a_n9246_1446# VP a_n9706_n894# B nfet_03v3 ad=2.1616p pd=8.28u as=2.1616p ps=8.28u w=7.72u l=1.7u
X63 OUT VN a_n9706_n894# B nfet_03v3 ad=2.1616p pd=8.28u as=2.1616p ps=8.28u w=7.72u l=1.7u
X64 OUT VN a_n9706_n894# B nfet_03v3 ad=2.1616p pd=8.28u as=2.1616p ps=8.28u w=7.72u l=1.7u
X65 a_n9706_n894# VN OUT B nfet_03v3 ad=2.1616p pd=8.28u as=2.1616p ps=8.28u w=7.72u l=1.7u
X66 a_n9246_1446# VP a_n9706_n894# B nfet_03v3 ad=2.1616p pd=8.28u as=2.1616p ps=8.28u w=7.72u l=1.7u
X67 OUT VN a_n9706_n894# B nfet_03v3 ad=2.1616p pd=8.28u as=2.1616p ps=8.28u w=7.72u l=1.7u
X68 a_n9706_n894# VN OUT B nfet_03v3 ad=2.1616p pd=8.28u as=2.1616p ps=8.28u w=7.72u l=1.7u
X69 a_n9246_1446# VP a_n9706_n894# B nfet_03v3 ad=2.1616p pd=8.28u as=2.1616p ps=8.28u w=7.72u l=1.7u
X70 a_n9706_n894# VP a_n9246_1446# B nfet_03v3 ad=2.1616p pd=8.28u as=2.1616p ps=8.28u w=7.72u l=1.7u
X71 a_n9706_n894# VP a_n9246_1446# B nfet_03v3 ad=2.1616p pd=8.28u as=2.1616p ps=8.28u w=7.72u l=1.7u
X72 a_n9706_n894# VN OUT B nfet_03v3 ad=2.1616p pd=8.28u as=2.1616p ps=8.28u w=7.72u l=1.7u
X73 a_n9706_n894# VP a_n9246_1446# B nfet_03v3 ad=2.1616p pd=8.28u as=2.1616p ps=8.28u w=7.72u l=1.7u
X74 a_n9246_1446# VP a_n9706_n894# B nfet_03v3 ad=2.1616p pd=8.28u as=2.1616p ps=8.28u w=7.72u l=1.7u
X75 a_n9706_n894# VN OUT B nfet_03v3 ad=2.1616p pd=8.28u as=2.1616p ps=8.28u w=7.72u l=1.7u
X76 OUT VN a_n9706_n894# B nfet_03v3 ad=4.632p pd=16.64u as=2.1616p ps=8.28u w=7.72u l=1.7u
X77 OUT VN a_n9706_n894# B nfet_03v3 ad=4.632p pd=16.64u as=2.1616p ps=8.28u w=7.72u l=1.7u
X78 a_n9706_n894# VN OUT B nfet_03v3 ad=2.1616p pd=8.28u as=2.1616p ps=8.28u w=7.72u l=1.7u
X79 a_n9706_n894# VN OUT B nfet_03v3 ad=2.1616p pd=8.28u as=2.1616p ps=8.28u w=7.72u l=1.7u
X80 OUT VN a_n9706_n894# B nfet_03v3 ad=2.1616p pd=8.28u as=2.1616p ps=8.28u w=7.72u l=1.7u
X81 OUT a_n9246_1446# VDD VDD pfet_03v3 ad=2.616p pd=9.92u as=2.616p ps=9.92u w=4.36u l=0.33u
X82 a_n9706_n894# VN OUT B nfet_03v3 ad=2.1616p pd=8.28u as=2.1616p ps=8.28u w=7.72u l=1.7u
X83 B B B B nfet_03v3 ad=4.4776p pd=16.6u as=0 ps=0 w=7.72u l=1.7u
X84 a_n9246_1446# VP a_n9706_n894# B nfet_03v3 ad=2.1616p pd=8.28u as=2.1616p ps=8.28u w=7.72u l=1.7u
X85 a_n9706_n894# VN OUT B nfet_03v3 ad=2.1616p pd=8.28u as=2.1616p ps=8.28u w=7.72u l=1.7u
X86 a_n9706_n894# VP a_n9246_1446# B nfet_03v3 ad=2.1616p pd=8.28u as=2.1616p ps=8.28u w=7.72u l=1.7u
X87 a_n9706_n894# VN OUT B nfet_03v3 ad=2.1616p pd=8.28u as=2.1616p ps=8.28u w=7.72u l=1.7u
X88 a_n9706_n894# VP a_n9246_1446# B nfet_03v3 ad=2.1616p pd=8.28u as=2.1616p ps=8.28u w=7.72u l=1.7u
X89 OUT VN a_n9706_n894# B nfet_03v3 ad=2.1616p pd=8.28u as=2.1616p ps=8.28u w=7.72u l=1.7u
X90 a_n9246_1446# VP a_n9706_n894# B nfet_03v3 ad=2.1616p pd=8.28u as=2.1616p ps=8.28u w=7.72u l=1.7u
X91 a_n9706_n894# VN OUT B nfet_03v3 ad=2.1616p pd=8.28u as=2.1616p ps=8.28u w=7.72u l=1.7u
X92 OUT VN a_n9706_n894# B nfet_03v3 ad=2.1616p pd=8.28u as=2.1616p ps=8.28u w=7.72u l=1.7u
X93 a_n9246_1446# VP a_n9706_n894# B nfet_03v3 ad=2.1616p pd=8.28u as=2.1616p ps=8.28u w=7.72u l=1.7u
X94 OUT VN a_n9706_n894# B nfet_03v3 ad=2.1616p pd=8.28u as=2.1616p ps=8.28u w=7.72u l=1.7u
X95 a_n9246_1446# VP a_n9706_n894# B nfet_03v3 ad=2.1616p pd=8.28u as=2.1616p ps=8.28u w=7.72u l=1.7u
C0 VDD OUT 2.06885f
C1 VDD a_n9246_1446# 3.69949f
C2 OUT a_n9246_1446# 3.90003f
C3 VP VSS 0
C4 VSS a_n9706_n894# 0.50567f
C5 VP VN 8.05411f
C6 VN a_n9706_n894# 17.5814f
C7 IBIAS a_n9706_n894# 0.15782f
C8 VSS OUT 0
C9 VSS a_n9246_1446# 0
C10 VDD VN 0.20217f
C11 VN OUT 16.9771f
C12 VN a_n9246_1446# 0.31446f
C13 VP a_n9706_n894# 17.5902f
C14 IBIAS OUT 0
C15 IBIAS a_n9246_1446# 0.00123f
C16 VDD VP 0.01543f
C17 VP OUT 0.94442f
C18 VDD a_n9706_n894# 0
C19 VN VSS 0
C20 VP a_n9246_1446# 17.6222f
C21 a_n9706_n894# OUT 16.4212f
C22 a_n9706_n894# a_n9246_1446# 16.5288f
C23 IBIAS VSS 1.12633f
C24 VSS B 1.16754f
C25 IBIAS B 3.24395f
C26 VN B 32.9525f
C27 VP B 32.0902f
C28 OUT B 14.3748f
C29 VDD B 19.4872f
C30 a_n9706_n894# B 18.438f ; **FLOATING
C31 a_n9246_1446# B 14.8423f ; **FLOATING
.ends
