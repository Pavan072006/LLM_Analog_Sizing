* NGSPICE file created from ota5t.ext - technology: gf180mcuD

.subckt ota5t B VSS IBIAS VN VP VDD OUT
X0 a_n2494_1466# VP a_n2788_n760# B nfet_03v3 ad=1.9964p pd=7.69u as=1.9964p ps=7.69u w=7.13u l=0.87u
X1 a_n2788_n760# VP a_n2494_1466# B nfet_03v3 ad=1.9964p pd=7.69u as=1.9964p ps=7.69u w=7.13u l=0.87u
X2 OUT VN a_n2788_n760# B nfet_03v3 ad=1.9964p pd=7.69u as=1.9964p ps=7.69u w=7.13u l=0.87u
X3 OUT VN a_n2788_n760# B nfet_03v3 ad=1.9964p pd=7.69u as=1.9964p ps=7.69u w=7.13u l=0.87u
X4 a_n2494_1466# VP a_n2788_n760# B nfet_03v3 ad=1.9964p pd=7.69u as=4.278p ps=15.46u w=7.13u l=0.87u
X5 a_n2788_n760# IBIAS VSS B nfet_03v3 ad=1.044p pd=4.68u as=1.044p ps=4.68u w=1.74u l=0.44u
X6 a_n2788_n760# VN OUT B nfet_03v3 ad=1.9964p pd=7.69u as=1.9964p ps=7.69u w=7.13u l=0.87u
X7 B B B B nfet_03v3 ad=1.0092p pd=4.64u as=37.12p ps=0.14192m w=1.74u l=0.44u
X8 IBIAS IBIAS VSS B nfet_03v3 ad=1.044p pd=4.68u as=1.044p ps=4.68u w=1.74u l=0.44u
X9 a_n2788_n760# VN OUT B nfet_03v3 ad=1.9964p pd=7.69u as=1.9964p ps=7.69u w=7.13u l=0.87u
X10 VDD VDD VDD VDD pfet_03v3 ad=2.5636p pd=10u as=15.5584p ps=60.08u w=4.42u l=0.76u
X11 a_n2494_1466# VP a_n2788_n760# B nfet_03v3 ad=1.9964p pd=7.69u as=1.9964p ps=7.69u w=7.13u l=0.87u
X12 a_n2788_n760# VN OUT B nfet_03v3 ad=1.9964p pd=7.69u as=1.9964p ps=7.69u w=7.13u l=0.87u
X13 B B B B nfet_03v3 ad=4.1354p pd=15.42u as=0 ps=0 w=7.13u l=0.87u
X14 OUT VN a_n2788_n760# B nfet_03v3 ad=4.278p pd=15.46u as=1.9964p ps=7.69u w=7.13u l=0.87u
X15 a_n2494_1466# VP a_n2788_n760# B nfet_03v3 ad=4.278p pd=15.46u as=1.9964p ps=7.69u w=7.13u l=0.87u
X16 a_n2494_1466# VP a_n2788_n760# B nfet_03v3 ad=1.9964p pd=7.69u as=1.9964p ps=7.69u w=7.13u l=0.87u
X17 a_n2788_n760# VN OUT B nfet_03v3 ad=1.9964p pd=7.69u as=1.9964p ps=7.69u w=7.13u l=0.87u
X18 a_n2788_n760# VN OUT B nfet_03v3 ad=1.9964p pd=7.69u as=1.9964p ps=7.69u w=7.13u l=0.87u
X19 a_n2494_1466# VP a_n2788_n760# B nfet_03v3 ad=1.9964p pd=7.69u as=1.9964p ps=7.69u w=7.13u l=0.87u
X20 a_n2788_n760# VN OUT B nfet_03v3 ad=1.9964p pd=7.69u as=1.9964p ps=7.69u w=7.13u l=0.87u
X21 B B B B nfet_03v3 ad=4.1354p pd=15.42u as=0 ps=0 w=7.13u l=0.87u
X22 a_n2788_n760# VN OUT B nfet_03v3 ad=1.9964p pd=7.69u as=1.9964p ps=7.69u w=7.13u l=0.87u
X23 a_n2788_n760# VN OUT B nfet_03v3 ad=1.9964p pd=7.69u as=1.9964p ps=7.69u w=7.13u l=0.87u
X24 a_n2494_1466# a_n2494_1466# VDD VDD pfet_03v3 ad=2.652p pd=10.04u as=2.652p ps=10.04u w=4.42u l=0.76u
X25 OUT VN a_n2788_n760# B nfet_03v3 ad=1.9964p pd=7.69u as=4.278p ps=15.46u w=7.13u l=0.87u
X26 a_n2494_1466# VP a_n2788_n760# B nfet_03v3 ad=1.9964p pd=7.69u as=1.9964p ps=7.69u w=7.13u l=0.87u
X27 a_n2494_1466# VP a_n2788_n760# B nfet_03v3 ad=1.9964p pd=7.69u as=1.9964p ps=7.69u w=7.13u l=0.87u
X28 OUT VN a_n2788_n760# B nfet_03v3 ad=1.9964p pd=7.69u as=4.278p ps=15.46u w=7.13u l=0.87u
X29 OUT VN a_n2788_n760# B nfet_03v3 ad=1.9964p pd=7.69u as=1.9964p ps=7.69u w=7.13u l=0.87u
X30 VDD VDD VDD VDD pfet_03v3 ad=2.5636p pd=10u as=0 ps=0 w=4.42u l=0.76u
X31 a_n2788_n760# VP a_n2494_1466# B nfet_03v3 ad=1.9964p pd=7.69u as=1.9964p ps=7.69u w=7.13u l=0.87u
X32 OUT VN a_n2788_n760# B nfet_03v3 ad=1.9964p pd=7.69u as=1.9964p ps=7.69u w=7.13u l=0.87u
X33 a_n2788_n760# VP a_n2494_1466# B nfet_03v3 ad=1.9964p pd=7.69u as=1.9964p ps=7.69u w=7.13u l=0.87u
X34 OUT VN a_n2788_n760# B nfet_03v3 ad=1.9964p pd=7.69u as=1.9964p ps=7.69u w=7.13u l=0.87u
X35 OUT a_n2494_1466# VDD VDD pfet_03v3 ad=2.652p pd=10.04u as=2.652p ps=10.04u w=4.42u l=0.76u
X36 a_n2788_n760# VP a_n2494_1466# B nfet_03v3 ad=1.9964p pd=7.69u as=1.9964p ps=7.69u w=7.13u l=0.87u
X37 a_n2788_n760# VP a_n2494_1466# B nfet_03v3 ad=1.9964p pd=7.69u as=1.9964p ps=7.69u w=7.13u l=0.87u
X38 B B B B nfet_03v3 ad=4.1354p pd=15.42u as=0 ps=0 w=7.13u l=0.87u
X39 B B B B nfet_03v3 ad=1.0092p pd=4.64u as=0 ps=0 w=1.74u l=0.44u
X40 OUT VN a_n2788_n760# B nfet_03v3 ad=1.9964p pd=7.69u as=1.9964p ps=7.69u w=7.13u l=0.87u
X41 OUT VN a_n2788_n760# B nfet_03v3 ad=4.278p pd=15.46u as=1.9964p ps=7.69u w=7.13u l=0.87u
X42 a_n2494_1466# VP a_n2788_n760# B nfet_03v3 ad=4.278p pd=15.46u as=1.9964p ps=7.69u w=7.13u l=0.87u
X43 B B B B nfet_03v3 ad=4.1354p pd=15.42u as=0 ps=0 w=7.13u l=0.87u
X44 a_n2788_n760# VP a_n2494_1466# B nfet_03v3 ad=1.9964p pd=7.69u as=1.9964p ps=7.69u w=7.13u l=0.87u
X45 a_n2788_n760# VP a_n2494_1466# B nfet_03v3 ad=1.9964p pd=7.69u as=1.9964p ps=7.69u w=7.13u l=0.87u
X46 a_n2788_n760# VP a_n2494_1466# B nfet_03v3 ad=1.9964p pd=7.69u as=1.9964p ps=7.69u w=7.13u l=0.87u
X47 a_n2494_1466# VP a_n2788_n760# B nfet_03v3 ad=1.9964p pd=7.69u as=4.278p ps=15.46u w=7.13u l=0.87u
C0 VP OUT 0.41865f
C1 VDD a_n2788_n760# 0
C2 VN VSS 0
C3 VP a_n2494_1466# 5.12387f
C4 a_n2788_n760# OUT 9.52904f
C5 a_n2788_n760# a_n2494_1466# 9.56576f
C6 IBIAS VSS 1.01492f
C7 VDD OUT 1.90192f
C8 VDD a_n2494_1466# 3.977f
C9 OUT a_n2494_1466# 1.64077f
C10 VP VSS 0
C11 VSS a_n2788_n760# 0.5973f
C12 VP VN 3.52433f
C13 VN a_n2788_n760# 4.7878f
C14 IBIAS a_n2788_n760# 0.11106f
C15 VSS OUT 0
C16 VSS a_n2494_1466# 0
C17 VDD VN 0.23261f
C18 VN OUT 4.90877f
C19 VN a_n2494_1466# 0.20704f
C20 VP a_n2788_n760# 4.79676f
C21 IBIAS OUT 0
C22 IBIAS a_n2494_1466# 0
C23 VDD VP 0.01765f
C24 VSS B 1.01608f
C25 IBIAS B 2.02217f
C26 VN B 10.459f
C27 VP B 10.3438f
C28 OUT B 6.09859f
C29 VDD B 22.1773f
C30 a_n2788_n760# B 9.14394f ; **FLOATING
C31 a_n2494_1466# B 6.2976f ; **FLOATING
.ends
