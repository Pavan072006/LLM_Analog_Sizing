* NGSPICE file created from ota5t.ext - technology: gf180mcuD

.subckt ota5t B VSS IBIAS VN VP VDD OUT
X0 a_n2175_3456# a_n2175_3456# VDD VDD pfet_03v3 ad=3.492p pd=12.84u as=3.492p ps=12.84u w=5.82u l=2u
X1 IBIAS IBIAS VSS B nfet_03v3 ad=2.07p pd=8.1u as=2.07p ps=8.1u w=3.45u l=0.5u
X2 B B B B nfet_03v3 ad=2.001p pd=8.06u as=14.1752p ps=62.8u w=3.45u l=0.5u
X3 a_n2175_3456# VP a_n638_572# B nfet_03v3 ad=0.3724p pd=1.89u as=0.798p ps=3.86u w=1.33u l=0.5u
X4 B B B B nfet_03v3 ad=0.7714p pd=3.82u as=0 ps=0 w=1.33u l=0.5u
X5 a_n638_572# VN OUT B nfet_03v3 ad=0.798p pd=3.86u as=0.3724p ps=1.89u w=1.33u l=0.5u
X6 B B B B nfet_03v3 ad=0.7714p pd=3.82u as=0 ps=0 w=1.33u l=0.5u
X7 VDD VDD VDD VDD pfet_03v3 ad=3.3756p pd=12.8u as=34.4544p ps=0.12824m w=5.82u l=2u
X8 B B B B nfet_03v3 ad=0.7714p pd=3.82u as=0 ps=0 w=1.33u l=0.5u
X9 OUT a_n2175_3456# VDD VDD pfet_03v3 ad=3.492p pd=12.84u as=3.492p ps=12.84u w=5.82u l=2u
X10 B B B B nfet_03v3 ad=2.001p pd=8.06u as=0 ps=0 w=3.45u l=0.5u
X11 OUT a_n2175_3456# VDD VDD pfet_03v3 ad=3.492p pd=12.84u as=3.492p ps=12.84u w=5.82u l=2u
X12 a_n2175_3456# VP a_n638_572# B nfet_03v3 ad=0.3724p pd=1.89u as=0.798p ps=3.86u w=1.33u l=0.5u
X13 a_n638_572# VP a_n2175_3456# B nfet_03v3 ad=0.798p pd=3.86u as=0.3724p ps=1.89u w=1.33u l=0.5u
X14 OUT VN a_n638_572# B nfet_03v3 ad=0.3724p pd=1.89u as=0.798p ps=3.86u w=1.33u l=0.5u
X15 OUT VN a_n638_572# B nfet_03v3 ad=0.3724p pd=1.89u as=0.798p ps=3.86u w=1.33u l=0.5u
X16 OUT a_n2175_3456# VDD VDD pfet_03v3 ad=3.492p pd=12.84u as=3.492p ps=12.84u w=5.82u l=2u
X17 B B B B nfet_03v3 ad=0.7714p pd=3.82u as=0 ps=0 w=1.33u l=0.5u
X18 a_n638_572# VP a_n2175_3456# B nfet_03v3 ad=0.798p pd=3.86u as=0.3724p ps=1.89u w=1.33u l=0.5u
X19 a_n2175_3456# a_n2175_3456# VDD VDD pfet_03v3 ad=3.492p pd=12.84u as=3.492p ps=12.84u w=5.82u l=2u
X20 a_n638_572# IBIAS VSS B nfet_03v3 ad=2.07p pd=8.1u as=2.07p ps=8.1u w=3.45u l=0.5u
X21 a_n638_572# VN OUT B nfet_03v3 ad=0.798p pd=3.86u as=0.3724p ps=1.89u w=1.33u l=0.5u
X22 a_n2175_3456# a_n2175_3456# VDD VDD pfet_03v3 ad=3.492p pd=12.84u as=3.492p ps=12.84u w=5.82u l=2u
X23 VDD VDD VDD VDD pfet_03v3 ad=3.3756p pd=12.8u as=0 ps=0 w=5.82u l=2u
.ends
